.PARAM Vdd_val = 1.8                  $ supply-1 voltage
.PARAM Vss_val = 0                    $ supply-0 voltage
.PARAM beta = 2                       $ un/up
.PARAM L = 180n                       $ Channel length
.PARAM Wn_min = 220n                  $ Minimum Transistor width for n-types
.PARAM Wp_min = 'beta * Wn_min'       $ Minimum Transistor width for p-types
